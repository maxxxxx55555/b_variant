* Задание 1-2, вариант 22. Цепь постоянного тока.
* Узел 3 схемы - базисный (узел 0). У источника V первым указан узел
* со знаком "+", т.е. тот, на который направлена стрелка ЭДС.
V2 e2 n1 DC 64
R6 e2 n2 54
R4 n1 n2 38
V1 d n2 DC 290
R5 d 0 93
R1 n1 0 88
R3 n1 0 93
I1 0 f DC 2.97
R2 f n1 21
.options numdgt=10
.control
set noaskquit
op
print v(n1) v(n2) v(f) v(d) v(e2)
print @r1[i] @r3[i] @r4[i] @r5[i] @r6[i] @r2[i]
print i(v1) i(v2)
save @r1[i] @r3[i] @r4[i] @r5[i] @r6[i]
dc V1 0 400 5
wrdata dc12.txt @r1[i] @r3[i] @r4[i] @r5[i] @r6[i]
.endc
.end
