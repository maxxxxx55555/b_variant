* DZ1 variant 22, task 2-2 (AC), LTspice netlist
V2 N001 n1 SINE(0 284 1k) AC 284 0
L2 N001 N002 10m
C2 N002 n2 0.71u
R1 n1 n3 23
L1 n1 N003 6m
V1 n3 N003 SINE(0 130 1k) AC 130 0
C1 n3 0 0.83u
Rg n3 0 1e12
R2 N004 n2 6
I1 0 N004 SINE(0 0.49 1k) AC 0.49 0
C3 n2 0 0.52u
R3 n2 g2 94
L3 g2 0 12m
.ac dec 20 100 10k
.meas ac iR1_mag FIND mag(I(R1)) AT 1k
.meas ac iR1_ph FIND ph(I(R1)) AT 1k
.meas ac iL1_mag FIND mag(I(L1)) AT 1k
.meas ac iL1_ph FIND ph(I(L1)) AT 1k
.meas ac iL2_mag FIND mag(I(L2)) AT 1k
.meas ac iL2_ph FIND ph(I(L2)) AT 1k
.meas ac iC1_mag FIND mag(I(C1)) AT 1k
.meas ac iC1_ph FIND ph(I(C1)) AT 1k
.meas ac iR2_mag FIND mag(I(R2)) AT 1k
.meas ac iR2_ph FIND ph(I(R2)) AT 1k
.meas ac iC3_mag FIND mag(I(C3)) AT 1k
.meas ac iC3_ph FIND ph(I(C3)) AT 1k
.meas ac iL3_mag FIND mag(I(L3)) AT 1k
.meas ac iL3_ph FIND ph(I(L3)) AT 1k
.meas ac vn1_mag FIND mag(V(n1)) AT 1k
.meas ac vn1_ph FIND ph(V(n1)) AT 1k
.meas ac vn2_mag FIND mag(V(n2)) AT 1k
.meas ac vn2_ph FIND ph(V(n2)) AT 1k
.meas ac vn3_mag FIND mag(V(n3)) AT 1k
.meas ac vn3_ph FIND ph(V(n3)) AT 1k
.meas ac vg2_mag FIND mag(V(g2)) AT 1k
.meas ac vg2_ph FIND ph(V(g2)) AT 1k
.end
