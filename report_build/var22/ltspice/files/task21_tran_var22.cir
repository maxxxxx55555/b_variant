* DZ1 variant 22, task 2-1 (transient), LTspice netlist
R2 n1 nv 77
V1 0 nv 309
R1 nx n1 100
I1 0 nx 1.47
R3 n1 ns 38
S1 ns n2 ctrl 0 SWM
R4 n2 0 36
L1 n2 n4 5m
R5 n4 n3 17
C1 n3 0 1u
Vc ctrl 0 PULSE(1 0 200u 1n 1n 1 2)
.model SWM SW(Ron=1u Roff=1G Vt=0.5 Vh=0.1)
.tran 0 1.7m 0 0.2u
.options plotwinsize=0 numdgt=15
.meas tran uc_before FIND V(n3) AT 150u
.meas tran il_before FIND I(L1) AT 150u
.meas tran uc_0 FIND V(n3) AT 200u
.meas tran il_0 FIND I(L1) AT 200u
.meas tran uc_50 FIND V(n3) AT 250u
.meas tran il_50 FIND I(L1) AT 250u
.meas tran uc_100 FIND V(n3) AT 300u
.meas tran il_100 FIND I(L1) AT 300u
.meas tran uc_200 FIND V(n3) AT 400u
.meas tran il_200 FIND I(L1) AT 400u
.meas tran uc_300 FIND V(n3) AT 500u
.meas tran il_300 FIND I(L1) AT 500u
.meas tran uc_400 FIND V(n3) AT 600u
.meas tran il_400 FIND I(L1) AT 600u
.meas tran uc_600 FIND V(n3) AT 800u
.meas tran il_600 FIND I(L1) AT 800u
.meas tran uc_800 FIND V(n3) AT 1000u
.meas tran il_800 FIND I(L1) AT 1000u
.end
